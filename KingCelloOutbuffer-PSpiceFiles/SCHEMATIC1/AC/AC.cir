** Profile: "SCHEMATIC1-AC"  [ D:\DevelopWorkSpace\Github\ORCAD_Projects\KingCelloOutbuffer-PSpiceFiles\SCHEMATIC1\AC.sim ]

** Creating circuit file "AC.cir"
** WARNING: THIS AUTOMATICALLY GENERATED FILE MAY BE OVERWRITTEN BY SUBSEQUENT SIMULATIONS

*Libraries:
* Profile Libraries :
* Local Libraries :
* From [PSPICE NETLIST] section of D:\DevelopProgramFiles\Cadence\SPB_16.5\tools\PSpice\PSpice.ini file:
.lib "nom.lib"

*Analysis directives:
.AC DEC 100 0.01 100MEG
.PROBE V(alias(*)) I(alias(*)) W(alias(*)) D(alias(*)) NOISE(alias(*))
.INC "..\SCHEMATIC1.net"

.END
